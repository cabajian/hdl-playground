{
  name: "counter",
  cip_id: "0",
  revisions: [
    {
      version: "1.0.0",
      life_stage: "L1",
      design_stage: "D1",
      verification_stage: "V1",
      dif_stage: "S1",
      notes: "Initial version"
    }
  ],
  clocking: [{clock: "clk_i", reset: "rst_ni"}],
  bus_interfaces: [
    { protocol: "tlul", direction: "device" }
  ],
  regwidth: 32,
  registers: [
    {
      name: "count",
      desc: "Current count value",
      swaccess: "rw",
      hwaccess: "hrw",
      fields: [
        { bits: "3:0", name: "val", desc: "Count value" }
      ]
    }
  ]
}
